************************************************************************
* auCdl Netlist:
*
* Library Name:  WorkStation
* Top Cell Name: IF_NEURON_FULL
* View Name:     schematic
* Netlisted on:  Jul 19 10:17:34 2026
************************************************************************

*.BIPOLAR
*.RESI = 2000
*.RESVAL
*.CAPVAL
*.DIOPERI
*.DIOAREA
*.EQUATION
*.SCALE METER
*.MEGA
.PARAM

*.GLOBAL VDD!
+        gnd!

*.PIN VDD!
*+    gnd!

************************************************************************
* Library Name: WorkStation
* Cell Name:    INV
* View Name:    schematic
************************************************************************

.SUBCKT INV VDD! gnd! input output
*.PININFO input:I output:O VDD!:B gnd!:B
MPM0 output input VDD! VDD! p18 W=1u L=180n m=1
MNM0 output input gnd! gnd! n18 W=500n L=180n m=1
.ENDS

************************************************************************
* Library Name: WorkStation
* Cell Name:    TG
* View Name:    schematic
************************************************************************

.SUBCKT TG C C_N VDD! gnd! input output
*.PININFO C:I C_N:I input:I output:O VDD!:B gnd!:B
MNM0 input C_N output gnd! n18 W=500n L=180n m=1
MPM0 input C output VDD! p18 W=1u L=180n m=1
.ENDS

************************************************************************
* Library Name: WorkStation
* Cell Name:    XNOR2
* View Name:    schematic
************************************************************************

.SUBCKT XNOR2 A B VDD! XNOR_OUT gnd!
*.PININFO A:I B:I XNOR_OUT:O VDD!:B gnd!:B
XI4 VDD! gnd! net3 XNOR_OUT / INV
XI1 VDD! gnd! B net2 / INV
XI0 VDD! gnd! A net4 / INV
XI3 net4 A VDD! gnd! net2 net3 / TG
XI2 A net4 VDD! gnd! B net3 / TG
.ENDS

************************************************************************
* Library Name: WorkStation
* Cell Name:    XOR2
* View Name:    schematic
************************************************************************

.SUBCKT XOR2 A B VDD! gnd! output
*.PININFO A:I B:I output:O VDD!:B gnd!:B
XI0 A B VDD! net1 gnd! / XNOR2
XI1 VDD! gnd! net1 output / INV
.ENDS

************************************************************************
* Library Name: WorkStation
* Cell Name:    NAND2
* View Name:    schematic
************************************************************************

.SUBCKT NAND2 A B VDD! gnd! output
*.PININFO A:I B:I output:O VDD!:B gnd!:B
MNM1 net1 B gnd! gnd! n18 W=2u L=180n m=1
MNM0 output A net1 net1 n18 W=2u L=180n m=1
MPM1 output B VDD! VDD! p18 W=1u L=180n m=1
MPM0 output A VDD! VDD! p18 W=1u L=180n m=1
.ENDS

************************************************************************
* Library Name: WorkStation
* Cell Name:    AND2
* View Name:    schematic
************************************************************************

.SUBCKT AND2 A B VDD! gnd! output
*.PININFO A:I B:I output:O VDD!:B gnd!:B
XI0 VDD! gnd! net1 output / INV
XI1 A B VDD! gnd! net1 / NAND2
.ENDS

************************************************************************
* Library Name: WorkStation
* Cell Name:    NOR2
* View Name:    schematic
************************************************************************

.SUBCKT NOR2 A B VDD! gnd! output
*.PININFO A:I B:I output:O VDD!:B gnd!:B
MNM1 output B gnd! gnd! n18 W=500n L=180n m=1
MNM0 output A gnd! gnd! n18 W=500n L=180n m=1
MPM1 output B net1 net1 p18 W=2u L=180n m=1
MPM0 net1 A VDD! VDD! p18 W=2u L=180n m=1
.ENDS

************************************************************************
* Library Name: WorkStation
* Cell Name:    OR2
* View Name:    schematic
************************************************************************

.SUBCKT OR2 A B VDD! gnd! output
*.PININFO A:I B:I output:O VDD!:B gnd!:B
XI0 A B VDD! gnd! net1 / NOR2
XI1 VDD! gnd! net1 output / INV
.ENDS

************************************************************************
* Library Name: WorkStation
* Cell Name:    CMP_GE
* View Name:    schematic
************************************************************************

.SUBCKT CMP_GE A0 A1 A2 A3 B0 B1 B2 B3 GE VDD! gnd!
*.PININFO A0:I A1:I A2:I A3:I B0:I B1:I B2:I B3:I GE:O VDD!:B gnd!:B
XI6 A0 B0 VDD! gnd! net13 / XOR2
XI4 A1 B1 VDD! gnd! net12 / XOR2
XI2 A2 B2 VDD! gnd! net11 / XOR2
XI0 A3 B3 VDD! gnd! net10 / XOR2
XI17 VDD! gnd! B0 net23 / INV
XI13 VDD! gnd! B1 net19 / INV
XI10 VDD! gnd! B2 net16 / INV
XI8 VDD! gnd! B3 net14 / INV
XI7 VDD! gnd! net13 net5 / INV
XI5 VDD! gnd! net12 net7 / INV
XI3 VDD! gnd! net11 net3 / INV
XI1 VDD! gnd! net10 net2 / INV
XI26 net6 net5 VDD! gnd! net8 / AND2
XI25 net4 net7 VDD! gnd! net6 / AND2
XI24 net2 net3 VDD! gnd! net4 / AND2
XI20 net25 net24 VDD! gnd! net1 / AND2
XI19 net21 net7 VDD! gnd! net25 / AND2
XI18 A0 net23 VDD! gnd! net24 / AND2
XI16 net21 net20 VDD! gnd! net22 / AND2
XI15 net2 net3 VDD! gnd! net21 / AND2
XI14 A1 net19 VDD! gnd! net20 / AND2
XI12 net2 net17 VDD! gnd! net18 / AND2
XI11 A2 net16 VDD! gnd! net17 / AND2
XI9 A3 net14 VDD! gnd! net15 / AND2
XI27 net8 net9 VDD! gnd! GE / OR2
XI23 net27 net1 VDD! gnd! net9 / OR2
XI22 net26 net22 VDD! gnd! net27 / OR2
XI21 net15 net18 VDD! gnd! net26 / OR2
.ENDS

************************************************************************
* Library Name: WorkStation
* Cell Name:    DFF
* View Name:    schematic
************************************************************************

.SUBCKT DFF CLK D Q Q_N VDD! gnd!
*.PININFO CLK:I D:I Q:O Q_N:O VDD!:B gnd!:B
XI3 CLK net4 VDD! gnd! net6 net8 / TG
XI2 net4 CLK VDD! gnd! net7 net8 / TG
XI1 net4 CLK VDD! gnd! net1 net7 / TG
XI0 CLK net4 VDD! gnd! D net7 / TG
XI10 VDD! gnd! Q Q_N / INV
XI9 VDD! gnd! net14 Q / INV
XI8 VDD! gnd! CLK net4 / INV
XI7 VDD! gnd! net11 net1 / INV
XI6 VDD! gnd! net14 net6 / INV
XI5 VDD! gnd! net8 net14 / INV
XI4 VDD! gnd! net7 net11 / INV
.ENDS

************************************************************************
* Library Name: WorkStation
* Cell Name:    SYNC_RESET
* View Name:    schematic
************************************************************************

.SUBCKT SYNC_RESET CLK CLR_SYNC SPIKE_RAW VDD! gnd!
*.PININFO CLK:I SPIKE_RAW:I VDD!:I gnd!:I CLR_SYNC:O
XI0 CLK SPIKE_RAW CLR_SYNC net1 VDD! gnd! / DFF
.ENDS

************************************************************************
* Library Name: WorkStation
* Cell Name:    MUX2to1
* View Name:    schematic
************************************************************************

.SUBCKT MUX2to1 IN0 IN1 SEL VDD! gnd! output
*.PININFO IN0:I IN1:I SEL:I output:O VDD!:B gnd!:B
XI0 VDD! gnd! SEL net1 / INV
XI2 SEL net1 VDD! gnd! IN1 output / TG
XI1 net1 SEL VDD! gnd! IN0 output / TG
.ENDS

************************************************************************
* Library Name: WorkStation
* Cell Name:    MUX4
* View Name:    schematic
************************************************************************

.SUBCKT MUX4 D00 D01 D02 D03 D10 D11 D12 D13 SEL VDD! Y0 Y1 Y2 Y3 gnd!
*.PININFO D00:I D01:I D02:I D03:I D10:I D11:I D12:I D13:I SEL:I VDD!:I gnd!:I
*.PININFO Y0:O Y1:O Y2:O Y3:O
XI3 D03 D13 SEL VDD! gnd! net4 / MUX2to1
XI2 D02 D12 SEL VDD! gnd! net3 / MUX2to1
XI1 D01 D11 SEL VDD! gnd! net1 / MUX2to1
XI0 D00 D10 SEL VDD! gnd! net2 / MUX2to1
XI7 VDD! gnd! net4 Y3 / INV
XI6 VDD! gnd! net3 Y2 / INV
XI5 VDD! gnd! net1 Y1 / INV
XI4 VDD! gnd! net2 Y0 / INV
.ENDS

************************************************************************
* Library Name: WorkStation
* Cell Name:    FA
* View Name:    schematic
************************************************************************

.SUBCKT FA A B CIN COUT SUM VDD! gnd!
*.PININFO A:I B:I CIN:I COUT:O SUM:O VDD!:B gnd!:B
XI6 A B VDD! gnd! net6 / XOR2
XI5 net6 CIN VDD! gnd! SUM / XOR2
XI3 net6 CIN VDD! gnd! net3 / AND2
XI2 A B VDD! gnd! net2 / AND2
XI4 net2 net3 VDD! gnd! COUT / OR2
.ENDS

************************************************************************
* Library Name: WorkStation
* Cell Name:    ADD4
* View Name:    schematic
************************************************************************

.SUBCKT ADD4 A[0] A[1] A[2] A[3] B[0] B[1] B[2] B[3] CIN COUT S[0] S[1] S[2]
+ S[3] VDD! gnd!
*.PININFO A[0]:I A[1]:I A[2]:I A[3]:I B[0]:I B[1]:I B[2]:I B[3]:I CIN:I COUT:O
*.PININFO S[0]:O S[1]:O S[2]:O S[3]:O VDD!:B gnd!:B
XI3 A[3] B[3] net3 COUT S[3] VDD! gnd! / FA
XI2 A[2] B[2] net2 net3 S[2] VDD! gnd! / FA
XI1 A[1] B[1] net1 net2 S[1] VDD! gnd! / FA
XI0 A[0] B[0] CIN net1 S[0] VDD! gnd! / FA
.ENDS

************************************************************************
* Library Name: WorkStation
* Cell Name:    DFF_CLR
* View Name:    schematic
************************************************************************

.SUBCKT DFF_CLR CLK CLR D Q Q_N VDD! gnd!
*.PININFO CLK:I CLR:I D:I Q:O Q_N:O VDD!:B gnd!:B
XI0 CLK net2 Q Q_N VDD! gnd! / DFF
XI1 D net1 VDD! gnd! net2 / AND2
XI2 VDD! gnd! CLR net1 / INV
.ENDS

************************************************************************
* Library Name: WorkStation
* Cell Name:    REG4
* View Name:    schematic
************************************************************************

.SUBCKT REG4 CLK CLR D[0] D[1] D[2] D[3] Q[0] Q[1] Q[2] Q[3] VDD! gnd!
*.PININFO CLK:I CLR:I D[0]:I D[1]:I D[2]:I D[3]:I Q[0]:O Q[1]:O Q[2]:O Q[3]:O
*.PININFO VDD!:B gnd!:B
XI3 CLK CLR D[3] Q[3] net4 VDD! gnd! / DFF_CLR
XI2 CLK CLR D[2] Q[2] net3 VDD! gnd! / DFF_CLR
XI1 CLK CLR D[1] Q[1] net2 VDD! gnd! / DFF_CLR
XI0 CLK CLR D[0] Q[0] net1 VDD! gnd! / DFF_CLR
.ENDS

************************************************************************
* Library Name: WorkStation
* Cell Name:    IF_INTEGRATOR
* View Name:    schematic
************************************************************************

.SUBCKT IF_INTEGRATOR CLK CLR SPIKE V0 V1 V2 V3 VDD! W0 W1 W2 W3 gnd!
*.PININFO CLK:I CLR:I SPIKE:I W0:I W1:I W2:I W3:I V0:O V1:O V2:O V3:O VDD!:B
*.PININFO gnd!:B
XI0 gnd! gnd! gnd! gnd! W0 W1 W2 W3 SPIKE VDD! net1 net2 net3 net4 gnd! / MUX4
XI1 net1 net2 net3 net4 V0 V1 V2 V3 gnd! net13 net12 net9 net10 net11 VDD!
+ gnd! / ADD4
XI2 CLK CLR net12 net9 net10 net11 V0 V1 V2 V3 VDD! gnd! / REG4
.ENDS

************************************************************************
* Library Name: WorkStation
* Cell Name:    IF_NEURON_FULL
* View Name:    schematic
************************************************************************

.SUBCKT IF_NEURON_FULL CLK CLR SPIKE_IN SPIKE_OUT V0 V1 V2 V3 VDD! Vth0 Vth1
+ Vth2 Vth3 W0 W1 W2 W3 gnd!
*.PININFO CLK:I CLR:I SPIKE_IN:I VDD!:I Vth0:I Vth1:I Vth2:I Vth3:I W0:I W1:I
*.PININFO W2:I W3:I gnd!:I SPIKE_OUT:O V0:O V1:O V2:O V3:O
XI0 V0 V1 V2 V3 Vth0 Vth1 Vth2 Vth3 net5 VDD! gnd! / CMP_GE
XI1 CLK net6 net5 VDD! gnd! / SYNC_RESET
XI4 net5 gnd! VDD! gnd! SPIKE_OUT / OR2
XI2 CLR net6 VDD! gnd! net7 / OR2
XI3 CLK net7 SPIKE_IN V0 V1 V2 V3 VDD! W0 W1 W2 W3 gnd! / IF_INTEGRATOR
.ENDS
